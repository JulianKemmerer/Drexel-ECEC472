simulator( 'spectre )
design(	 "/home/DREXEL/jvk27/simulation/ALU_SIM/spectre/schematic/netlist/netlist")
resultsDir( "/home/DREXEL/jvk27/simulation/ALU_SIM/spectre/schematic" )
modelFile(
    '("/home/ECEx72/IBM_CMOS7RF/IBM_PDK/cmrf7sf/relAM/Spectre/models/allModels.scs" "tt")
)
analysis('tran ?stop "1"  )
desVar(	  "phires" 0	)
desVar(	  "p5vonly" 0	)
desVar(	  "s" ""	)
envOption(
	'analysisOrder  list("tran")
)
option(	'tnom  "27"
)
temp( 27 )
run()
selectResult( 'tran )
plot(getData("/Data0<0>") getData("/Data0<1>") getData("/Data0<2>") getData("/Data0<3>") getData("/Data0<4>") getData("/Data0<5>") getData("/Data0<6>") getData("/Data0<7>") getData("/Data1<0>") getData("/Data1<1>") getData("/Data1<2>") getData("/Data1<3>") getData("/Data1<4>") getData("/Data1<5>") getData("/Data1<6>") getData("/Data1<7>") getData("/ALU_OP<0>") getData("/ALU_OP<1>") getData("/ALU_OP<2>") getData("/Out<0>") getData("/Out<1>") getData("/Out<2>") getData("/Out<3>") getData("/Out<4>") getData("/Out<5>") getData("/Out<6>") getData("/Out<7>") getData("/Zero") )
